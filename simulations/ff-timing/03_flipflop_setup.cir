* Broad sweep of rising-data setup and clock-to-Q delay
.param maxstep=0.25p
.step param delta list 500p 300p 200p 100p 50p 30p 20p 15p 10p 8p 6p 4p 2p 0p -2p -5p -10p -20p
.include "setup_bench.inc"
.end
